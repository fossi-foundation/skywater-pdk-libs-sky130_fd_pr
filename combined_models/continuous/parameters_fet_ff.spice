* Copyright 2020 The SkyWater PDK Authors
*
* Licensed under the Apache License, Version 2.0 (the "License");
* you may not use this file except in compliance with the License.
* You may obtain a copy of the License at
*
*     https://www.apache.org/licenses/LICENSE-2.0
*
* Unless required by applicable law or agreed to in writing, software
* distributed under the License is distributed on an "AS IS" BASIS,
* WITHOUT WARRANTIES OR CONDITIONS OF ANY KIND, either express or implied.
* See the License for the specific language governing permissions and
* limitations under the License.
*
* ./parameters_fet_ff.spice created from ./parameters.spice
*
.param sw_tox_lv_corner = {4.148e-09+corner_factor*-1.48e-10}
.param sw_tox_hv_corner = {1.16e-08+corner_factor*-5e-10}
* Process Monte Carlo:  For each process parameter X, X_mcz is a random
* draw (standard normal), which ngspice evaluates again at every place it
* is used.  X_mcd = X_mcz is evaluated only once, so that all devices
* share the same process value (one draw per die per simulation run).
.param sw_polycd_mcz = 'agauss(0,1,1)'
.param sw_polycd_mcd = 'sw_polycd_mcz'
.param sw_polycd = {0.0+corner_factor*-5.5e-09+process_mc_factor*MC_PR_SWITCH*1.5e-09*sw_polycd_mcd}
.param sw_activecd_mcz = 'agauss(0,1,1)'
.param sw_activecd_mcd = 'sw_activecd_mcz'
.param sw_activecd = {0.0+corner_factor*-2.25e-08+process_mc_factor*MC_PR_SWITCH*5e-09*sw_activecd_mcd}
.param sw_nw_rs_mult_mcz = 'agauss(0,1,1)'
.param sw_nw_rs_mult_mcd = 'sw_nw_rs_mult_mcz'
.param sw_nw_rs_mult = {(1.0+corner_factor*-0.2)*exp(process_mc_factor*MC_PR_SWITCH*0.12*sw_nw_rs_mult_mcd)}
.param sw_sky130_fd_pr__pfet_01v8_de_rd_mult = {1.0+corner_factor*-0.2}
.param sw_nsd_pw_cj_mcz = 'agauss(0,1,1)'
.param sw_nsd_pw_cj_mcd = 'sw_nsd_pw_cj_mcz'
.param sw_nsd_pw_cj = {(0.00135+corner_factor*-0.00022)*(1+process_mc_factor*MC_PR_SWITCH*0.025*sw_nsd_pw_cj_mcd)}
.param sw_psd_nw_cj_mcz = 'agauss(0,1,1)'
.param sw_psd_nw_cj_mcd = 'sw_psd_nw_cj_mcz'
.param sw_psd_nw_cj = {(0.0007408+corner_factor*-5.19e-05)*(1+process_mc_factor*MC_PR_SWITCH*0.025*sw_psd_nw_cj_mcd)}
.param sw_nw_pw_cj_mcz = 'agauss(0,1,1)'
.param sw_nw_pw_cj_mcd = 'sw_nw_pw_cj_mcz'
.param sw_nw_pw_cj = {(9e-05+corner_factor*-1.24e-05)*(1+process_mc_factor*MC_PR_SWITCH*0.025*sw_nw_pw_cj_mcd)}
.param sw_pw_dnw_cj_mcz = 'agauss(0,1,1)'
.param sw_pw_dnw_cj_mcd = 'sw_pw_dnw_cj_mcz'
.param sw_pw_dnw_cj = {(0.0003824+corner_factor*-8.09e-05)*(1+process_mc_factor*MC_PR_SWITCH*0.025*sw_pw_dnw_cj_mcd)}
.param sw_dnw_sub_cj_mcz = 'agauss(0,1,1)'
.param sw_dnw_sub_cj_mcd = 'sw_dnw_sub_cj_mcz'
.param sw_dnw_sub_cj = {(7.743e-05+corner_factor*-1.491e-05)*(1+process_mc_factor*MC_PR_SWITCH*0.025*sw_dnw_sub_cj_mcd)}
.param sw_nldd_mcz = 'agauss(0,1,1)'
.param sw_nldd_mcd = 'sw_nldd_mcz'
.param sw_nldd = {(1.0+corner_factor*-0.2)*(1+process_mc_factor*MC_PR_SWITCH*0.025*sw_nldd_mcd)}
.param sw_vth0_sky130_fd_pr__nfet_01v8 = {0.0+corner_factor*-0.015}
.param sw_u0_sky130_fd_pr__nfet_01v8 = {1.0+corner_factor*0.02}
.param sw_vsat_sky130_fd_pr__nfet_01v8 = {1.0+corner_factor*0.1}
.param sw_vth0_sky130_fd_pr__nfet_01v8_lvt = {0.0+corner_factor*-0.019}
.param sw_u0_sky130_fd_pr__nfet_01v8_lvt = {1.0+corner_factor*0.03}
.param sw_vth0_sky130_fd_pr__nfet_g5v0d10v5 = {0.0+corner_factor*-0.02}
.param sw_u0_sky130_fd_pr__nfet_g5v0d10v5 = {1.0+corner_factor*0.03}
.param sw_vsat_sky130_fd_pr__nfet_g5v0d10v5 = {1.0+corner_factor*0.1}
.param sw_vth0_sky130_fd_pr__nfet_01v8_nat = {0.0+corner_factor*-0.02}
.param sw_u0_sky130_fd_pr__nfet_01v8_nat = {1.0+corner_factor*0.03}
.param sw_vth0_sky130_fd_pr__nfet_01v8_zvt_mcz = 'agauss(0,1,1)'
.param sw_vth0_sky130_fd_pr__nfet_01v8_zvt_mcd = 'sw_vth0_sky130_fd_pr__nfet_01v8_zvt_mcz'
.param sw_vth0_sky130_fd_pr__nfet_01v8_zvt = {0.0+corner_factor*-0.02+process_mc_factor*MC_PR_SWITCH*0.007*sw_vth0_sky130_fd_pr__nfet_01v8_zvt_mcd}
.param sw_u0_sky130_fd_pr__nfet_01v8_zvt = {1.0+corner_factor*0.03}
.param sw_vth0_sky130_fd_pr__nfet_g5v0d16v0 = {0.0+corner_factor*-0.08}
.param sw_u0_sky130_fd_pr__nfet_g5v0d16v0 = {1.0+corner_factor*0.1}
.param sw_vsat_sky130_fd_pr__nfet_g5v0d16v0 = {1.0+corner_factor*0.25}
.param sw_vth0_sky130_fd_pr__pfet_01v8 = {0.0+corner_factor*0.01}
.param sw_u0_sky130_fd_pr__pfet_01v8 = {1.0+corner_factor*0.05}
.param sw_vsat_sky130_fd_pr__pfet_01v8 = {1.0+corner_factor*0.15}
.param sw_vth0_sky130_fd_pr__pfet_01v8_lvt = {0.0+corner_factor*0.09}
.param sw_u0_sky130_fd_pr__pfet_01v8_lvt = {1.0+corner_factor*0.07}
.param sw_vth0_sky130_fd_pr__pfet_01v8_hvt = {0.0+corner_factor*0.02}
.param sw_u0_sky130_fd_pr__pfet_01v8_hvt = {1.0+corner_factor*0.07}
.param sw_vsat_sky130_fd_pr__pfet_01v8_hvt = {1.0+corner_factor*0.2}
.param sw_vth0_nat_v5 = {-0.0105+corner_factor*-0.00764}
.param sw_vth0_sky130_fd_pr__pfet_g5v0d10v5 = {0.0+corner_factor*0.04}
.param sw_u0_sky130_fd_pr__pfet_g5v0d10v5 = {1.0+corner_factor*0.07}
.param sw_vsat_sky130_fd_pr__pfet_g5v0d10v5 = {1.0+corner_factor*0.1}
.param sw_vth0_sky130_fd_pr__pfet_g5v0d16v0 = {0.0+corner_factor*0.07}
.param sw_u0_sky130_fd_pr__pfet_g5v0d16v0 = {1.0+corner_factor*0.07}
.param sw_vsat_sky130_fd_pr__pfet_g5v0d16v0 = {1.0+corner_factor*0.1}
