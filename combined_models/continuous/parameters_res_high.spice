* Copyright 2020 The SkyWater PDK Authors
*
* Licensed under the Apache License, Version 2.0 (the "License");
* you may not use this file except in compliance with the License.
* You may obtain a copy of the License at
*
*     https://www.apache.org/licenses/LICENSE-2.0
*
* Unless required by applicable law or agreed to in writing, software
* distributed under the License is distributed on an "AS IS" BASIS,
* WITHOUT WARRANTIES OR CONDITIONS OF ANY KIND, either express or implied.
* See the License for the specific language governing permissions and
* limitations under the License.
*
* ./parameters_res_high.spice created from ./parameters.spice
*
* Process Monte Carlo:  For each process parameter X, X_mcz is a random
* draw (standard normal), which ngspice evaluates again at every place it
* is used.  X_mcd = X_mcz is evaluated only once, so that all devices
* share the same process value (one draw per die per simulation run).
.param sw_sky130_fd_pr__res_high_po_rs_mcz = 'agauss(0,1,1)'
.param sw_sky130_fd_pr__res_high_po_rs_mcd = 'sw_sky130_fd_pr__res_high_po_rs_mcz'
.param sw_sky130_fd_pr__res_high_po_rs = {(325.0+corner_factor*45.0)*(1+process_mc_factor*MC_PR_SWITCH*0.035*sw_sky130_fd_pr__res_high_po_rs_mcd)}
.param sw_sky130_fd_pr__res_xhigh_po_rs_mcz = 'agauss(0,1,1)'
.param sw_sky130_fd_pr__res_xhigh_po_rs_mcd = 'sw_sky130_fd_pr__res_xhigh_po_rs_mcz'
.param sw_sky130_fd_pr__res_xhigh_po_rs = {(2000.0+corner_factor*300.0)*(1+process_mc_factor*MC_PR_SWITCH*0.04*sw_sky130_fd_pr__res_xhigh_po_rs_mcd)}
.param sw_poly_head_res_mcz = 'agauss(0,1,1)'
.param sw_poly_head_res_mcd = 'sw_poly_head_res_mcz'
.param sw_poly_head_res = {(1.0+corner_factor*0.125)*(1+process_mc_factor*MC_PR_SWITCH*0.025*sw_poly_head_res_mcd)}
.param sw_sky130_fd_pr__res_generic_m1_rs_mcz = 'agauss(0,1,1)'
.param sw_sky130_fd_pr__res_generic_m1_rs_mcd = 'sw_sky130_fd_pr__res_generic_m1_rs_mcz'
.param sw_sky130_fd_pr__res_generic_m1_rs = {(0.124+corner_factor*0.019)*(1+process_mc_factor*MC_PR_SWITCH*0.05*sw_sky130_fd_pr__res_generic_m1_rs_mcd)}
.param sw_sky130_fd_pr__res_generic_m2_rs_mcz = 'agauss(0,1,1)'
.param sw_sky130_fd_pr__res_generic_m2_rs_mcd = 'sw_sky130_fd_pr__res_generic_m2_rs_mcz'
.param sw_sky130_fd_pr__res_generic_m2_rs = {(0.124+corner_factor*0.019)*(1+process_mc_factor*MC_PR_SWITCH*0.05*sw_sky130_fd_pr__res_generic_m2_rs_mcd)}
.param sw_sky130_fd_pr__res_generic_m3_rs_mcz = 'agauss(0,1,1)'
.param sw_sky130_fd_pr__res_generic_m3_rs_mcd = 'sw_sky130_fd_pr__res_generic_m3_rs_mcz'
.param sw_sky130_fd_pr__res_generic_m3_rs = {(0.046+corner_factor*0.007)*(1+process_mc_factor*MC_PR_SWITCH*0.05*sw_sky130_fd_pr__res_generic_m3_rs_mcd)}
.param sw_sky130_fd_pr__res_generic_m4_rs_mcz = 'agauss(0,1,1)'
.param sw_sky130_fd_pr__res_generic_m4_rs_mcd = 'sw_sky130_fd_pr__res_generic_m4_rs_mcz'
.param sw_sky130_fd_pr__res_generic_m4_rs = {(0.046+corner_factor*0.007)*(1+process_mc_factor*MC_PR_SWITCH*0.05*sw_sky130_fd_pr__res_generic_m4_rs_mcd)}
.param sw_sky130_fd_pr__res_generic_m5_rs = {0.0275+corner_factor*0.0045}
.param sw_m1_dw = {0.0+corner_factor*-2.5e-08}
.param sw_m2_dw = {0.0+corner_factor*-2.5e-08}
.param sw_m3_dw_mcz = 'agauss(0,1,1)'
.param sw_m3_dw_mcd = 'sw_m3_dw_mcz'
.param sw_m3_dw = {0.0+corner_factor*-6.5e-08+process_mc_factor*MC_PR_SWITCH*1.6e-08*sw_m3_dw_mcd}
.param sw_m4_dw_mcz = 'agauss(0,1,1)'
.param sw_m4_dw_mcd = 'sw_m4_dw_mcz'
.param sw_m4_dw = {0.0+corner_factor*-6.5e-08+process_mc_factor*MC_PR_SWITCH*1.6e-08*sw_m4_dw_mcd}
.param sw_m5_dw = {0.0+corner_factor*-1.7e-07}
.param sw_rcvia_mcz = 'agauss(0,1,1)'
.param sw_rcvia_mcd = 'sw_rcvia_mcz'
.param sw_rcvia = {(4.5+corner_factor*7.35)*exp(process_mc_factor*MC_PR_SWITCH*0.26*sw_rcvia_mcd)}
.param sw_rcvia2_mcz = 'agauss(0,1,1)'
.param sw_rcvia2_mcd = 'sw_rcvia2_mcz'
.param sw_rcvia2 = {(3.41+corner_factor*3.213)*exp(process_mc_factor*MC_PR_SWITCH*0.21*sw_rcvia2_mcd)}
.param sw_rcvia3_mcz = 'agauss(0,1,1)'
.param sw_rcvia3_mcd = 'sw_rcvia3_mcz'
.param sw_rcvia3 = {(3.41+corner_factor*3.213)*exp(process_mc_factor*MC_PR_SWITCH*0.21*sw_rcvia3_mcd)}
.param sw_rcvia4_mcz = 'agauss(0,1,1)'
.param sw_rcvia4_mcd = 'sw_rcvia4_mcz'
.param sw_rcvia4 = {(3.41+corner_factor*3.213)*exp(process_mc_factor*MC_PR_SWITCH*0.21*sw_rcvia4_mcd)}
.param sw_rcl1_mcz = 'agauss(0,1,1)'
.param sw_rcl1_mcd = 'sw_rcl1_mcz'
.param sw_rcl1 = {(9.3+corner_factor*9.31)*exp(process_mc_factor*MC_PR_SWITCH*0.39*sw_rcl1_mcd)}
.param sw_rl1_mcz = 'agauss(0,1,1)'
.param sw_rl1_mcd = 'sw_rl1_mcz'
.param sw_rl1 = {(12.3+corner_factor*2.5)*(1+process_mc_factor*MC_PR_SWITCH*0.05*sw_rl1_mcd)}
.param sw_rl1_dw = {0.0+corner_factor*-2e-08}
.param sw_rnw_mcz = 'agauss(0,1,1)'
.param sw_rnw_mcd = 'sw_rnw_mcz'
.param sw_rnw = {(1700.0+corner_factor*460.0)*(1+process_mc_factor*MC_PR_SWITCH*0.0375*sw_rnw_mcd)}
.param sw_rp1_mcz = 'agauss(0,1,1)'
.param sw_rp1_mcd = 'sw_rp1_mcz'
.param sw_rp1 = {(48.2+corner_factor*7.4)*(1+process_mc_factor*MC_PR_SWITCH*0.025*sw_rp1_mcd)}
.param sw_rcn_mcz = 'agauss(0,1,1)'
.param sw_rcn_mcd = 'sw_rcn_mcz'
.param sw_rcn = {(182.0+corner_factor*114.0)*exp(process_mc_factor*MC_PR_SWITCH*0.9*sw_rcn_mcd)}
.param sw_rcp1_mcz = 'agauss(0,1,1)'
.param sw_rcp1_mcd = 'sw_rcp1_mcz'
.param sw_rcp1 = {(145.0+corner_factor*84.0)*exp(process_mc_factor*MC_PR_SWITCH*0.86*sw_rcp1_mcd)}
.param sw_rdn_mcz = 'agauss(0,1,1)'
.param sw_rdn_mcd = 'sw_rdn_mcz'
.param sw_rdn = {(120.0+corner_factor*12.0)*(1+process_mc_factor*MC_PR_SWITCH*0.025*sw_rdn_mcd)}
.param sw_rdp_mcz = 'agauss(0,1,1)'
.param sw_rdp_mcd = 'sw_rdp_mcz'
.param sw_rdp = {(197.0+corner_factor*31.0)*(1+process_mc_factor*MC_PR_SWITCH*0.0375*sw_rdp_mcd)}
.param sw_pw_rs = {3816.0+corner_factor*1034.0}
