* SKY130 Spice File.
* Critical Model Parameters:
* Process Monte Carlo:  For each process parameter X, X_mcz is a random
* draw (standard normal), which ngspice evaluates again at every place it
* is used.  X_mcd = X_mcz is evaluated only once, so that all devices
* share the same process value (one draw per die per simulation run).
.param cnwvc_mcz = 'agauss(0,1,1)'
.param cnwvc_mcd = 'cnwvc_mcz'
.param cnwvc = {0.0+MC_PR_SWITCH*1.0*cnwvc_mcd}
.param diff_cd_mcz = 'agauss(0,1,1)'
.param diff_cd_mcd = 'diff_cd_mcz'
.param diff_cd = {0.0+MC_PR_SWITCH*1.5*diff_cd_mcd}
.param hvn_bodyeffect_mcz = 'agauss(0,1,1)'
.param hvn_bodyeffect_mcd = 'hvn_bodyeffect_mcz'
.param hvn_bodyeffect = {0.0+MC_PR_SWITCH*2.8*hvn_bodyeffect_mcd}
.param hvn_diode_mcz = 'agauss(0,1,1)'
.param hvn_diode_mcd = 'hvn_diode_mcz'
.param hvn_diode = {0.0+MC_PR_SWITCH*1.0*hvn_diode_mcd}
.param hvn_mobility_mcz = 'agauss(0,1,1)'
.param hvn_mobility_mcd = 'hvn_mobility_mcz'
.param hvn_mobility = {0.0+MC_PR_SWITCH*0.8*hvn_mobility_mcd}
.param hvn_saturation_mcz = 'agauss(0,1,1)'
.param hvn_saturation_mcd = 'hvn_saturation_mcz'
.param hvn_saturation = {0.0+MC_PR_SWITCH*0.6*hvn_saturation_mcd}
.param hvn_subvt_mcz = 'agauss(0,1,1)'
.param hvn_subvt_mcd = 'hvn_subvt_mcz'
.param hvn_subvt = {0.0+MC_PR_SWITCH*1.0*hvn_subvt_mcd}
.param hvn_threshold_mcz = 'agauss(0,1,1)'
.param hvn_threshold_mcd = 'hvn_threshold_mcz'
.param hvn_threshold = {0.0+MC_PR_SWITCH*1.5*hvn_threshold_mcd}
.param hvp_bodyeffect_mcz = 'agauss(0,1,1)'
.param hvp_bodyeffect_mcd = 'hvp_bodyeffect_mcz'
.param hvp_bodyeffect = {0.0+MC_PR_SWITCH*2.8*hvp_bodyeffect_mcd}
.param hvp_diode_mcz = 'agauss(0,1,1)'
.param hvp_diode_mcd = 'hvp_diode_mcz'
.param hvp_diode = {0.0+MC_PR_SWITCH*1.0*hvp_diode_mcd}
.param hvp_mobility_mcz = 'agauss(0,1,1)'
.param hvp_mobility_mcd = 'hvp_mobility_mcz'
.param hvp_mobility = {0.0+MC_PR_SWITCH*1.8*hvp_mobility_mcd}
.param hvp_saturation_mcz = 'agauss(0,1,1)'
.param hvp_saturation_mcd = 'hvp_saturation_mcz'
.param hvp_saturation = {0.0+MC_PR_SWITCH*1.8*hvp_saturation_mcd}
.param hvp_subvt_mcz = 'agauss(0,1,1)'
.param hvp_subvt_mcd = 'hvp_subvt_mcz'
.param hvp_subvt = {0.0+MC_PR_SWITCH*1.0*hvp_subvt_mcd}
.param hvp_threshold_mcz = 'agauss(0,1,1)'
.param hvp_threshold_mcd = 'hvp_threshold_mcz'
.param hvp_threshold = {0.0+MC_PR_SWITCH*1.5*hvp_threshold_mcd}
.param hvtox_mcz = 'agauss(0,1,1)'
.param hvtox_mcd = 'hvtox_mcz'
.param hvtox = {0.0+MC_PR_SWITCH*1.0*hvtox_mcd}
.param ic_cap_mcz = 'agauss(0,1,1)'
.param ic_cap_mcd = 'ic_cap_mcz'
.param ic_cap = {0.0+MC_PR_SWITCH*1.0*ic_cap_mcd}
.param ic_res_mcz = 'agauss(0,1,1)'
.param ic_res_mcd = 'ic_res_mcz'
.param ic_res = {0.0+MC_PR_SWITCH*1.0*ic_res_mcd}
.param ic_res_ndiff_mcz = 'agauss(0,1,1)'
.param ic_res_ndiff_mcd = 'ic_res_ndiff_mcz'
.param ic_res_ndiff = {0.0+MC_PR_SWITCH*1.0*ic_res_ndiff_mcd}
.param ic_res_pdiff_mcz = 'agauss(0,1,1)'
.param ic_res_pdiff_mcd = 'ic_res_pdiff_mcz'
.param ic_res_pdiff = {0.0+MC_PR_SWITCH*1.0*ic_res_pdiff_mcd}
.param ic_res_poly_mcz = 'agauss(0,1,1)'
.param ic_res_poly_mcd = 'ic_res_poly_mcz'
.param ic_res_poly = {0.0+MC_PR_SWITCH*1.0*ic_res_poly_mcd}
.param ic_res_pwell_mcz = 'agauss(0,1,1)'
.param ic_res_pwell_mcd = 'ic_res_pwell_mcz'
.param ic_res_pwell = {0.0+MC_PR_SWITCH*1.0*ic_res_pwell_mcd}
.param lvhp_bodyeffect_mcz = 'agauss(0,1,1)'
.param lvhp_bodyeffect_mcd = 'lvhp_bodyeffect_mcz'
.param lvhp_bodyeffect = {0.0+MC_PR_SWITCH*1.8*lvhp_bodyeffect_mcd}
.param lvhp_mobility_mcz = 'agauss(0,1,1)'
.param lvhp_mobility_mcd = 'lvhp_mobility_mcz'
.param lvhp_mobility = {0.0+MC_PR_SWITCH*2.0*lvhp_mobility_mcd}
.param lvhp_saturation_mcz = 'agauss(0,1,1)'
.param lvhp_saturation_mcd = 'lvhp_saturation_mcz'
.param lvhp_saturation = {0.0+MC_PR_SWITCH*1.1*lvhp_saturation_mcd}
.param lvhp_threshold_mcz = 'agauss(0,1,1)'
.param lvhp_threshold_mcd = 'lvhp_threshold_mcz'
.param lvhp_threshold = {0.0+MC_PR_SWITCH*0.8*lvhp_threshold_mcd}
.param lvln_bodyeffect_mcz = 'agauss(0,1,1)'
.param lvln_bodyeffect_mcd = 'lvln_bodyeffect_mcz'
.param lvln_bodyeffect = {0.0+MC_PR_SWITCH*2.0*lvln_bodyeffect_mcd}
.param lvln_mobility_mcz = 'agauss(0,1,1)'
.param lvln_mobility_mcd = 'lvln_mobility_mcz'
.param lvln_mobility = {0.0+MC_PR_SWITCH*0.6*lvln_mobility_mcd}
.param lvln_saturation_mcz = 'agauss(0,1,1)'
.param lvln_saturation_mcd = 'lvln_saturation_mcz'
.param lvln_saturation = {0.0+MC_PR_SWITCH*0.6*lvln_saturation_mcd}
.param lvln_threshold_mcz = 'agauss(0,1,1)'
.param lvln_threshold_mcd = 'lvln_threshold_mcz'
.param lvln_threshold = {0.0+MC_PR_SWITCH*0.6*lvln_threshold_mcd}
.param lvlp_bodyeffect_mcz = 'agauss(0,1,1)'
.param lvlp_bodyeffect_mcd = 'lvlp_bodyeffect_mcz'
.param lvlp_bodyeffect = {0.0+MC_PR_SWITCH*0.5*lvlp_bodyeffect_mcd}
.param lvlp_mobility_mcz = 'agauss(0,1,1)'
.param lvlp_mobility_mcd = 'lvlp_mobility_mcz'
.param lvlp_mobility = {0.0+MC_PR_SWITCH*0.3*lvlp_mobility_mcd}
.param lvlp_saturation_mcz = 'agauss(0,1,1)'
.param lvlp_saturation_mcd = 'lvlp_saturation_mcz'
.param lvlp_saturation = {0.0+MC_PR_SWITCH*0.3*lvlp_saturation_mcd}
.param lvlp_threshold_mcz = 'agauss(0,1,1)'
.param lvlp_threshold_mcd = 'lvlp_threshold_mcz'
.param lvlp_threshold = {0.0+MC_PR_SWITCH*1.3*lvlp_threshold_mcd}
.param lvn_bodyeffect_mcz = 'agauss(0,1,1)'
.param lvn_bodyeffect_mcd = 'lvn_bodyeffect_mcz'
.param lvn_bodyeffect = {0.0+MC_PR_SWITCH*2.0*lvn_bodyeffect_mcd}
.param lvn_diode_mcz = 'agauss(0,1,1)'
.param lvn_diode_mcd = 'lvn_diode_mcz'
.param lvn_diode = {0.0+MC_PR_SWITCH*1.0*lvn_diode_mcd}
.param lvn_mobility_mcz = 'agauss(0,1,1)'
.param lvn_mobility_mcd = 'lvn_mobility_mcz'
.param lvn_mobility = {0.0+MC_PR_SWITCH*0.6*lvn_mobility_mcd}
.param lvn_saturation_mcz = 'agauss(0,1,1)'
.param lvn_saturation_mcd = 'lvn_saturation_mcz'
.param lvn_saturation = {0.0+MC_PR_SWITCH*0.6*lvn_saturation_mcd}
.param lvn_subvt_mcz = 'agauss(0,1,1)'
.param lvn_subvt_mcd = 'lvn_subvt_mcz'
.param lvn_subvt = {0.0+MC_PR_SWITCH*1.0*lvn_subvt_mcd}
.param lvn_threshold_mcz = 'agauss(0,1,1)'
.param lvn_threshold_mcd = 'lvn_threshold_mcz'
.param lvn_threshold = {0.0+MC_PR_SWITCH*0.8*lvn_threshold_mcd}
.param lvp_bodyeffect_mcz = 'agauss(0,1,1)'
.param lvp_bodyeffect_mcd = 'lvp_bodyeffect_mcz'
.param lvp_bodyeffect = {0.0+MC_PR_SWITCH*1.0*lvp_bodyeffect_mcd}
.param lvp_diode_mcz = 'agauss(0,1,1)'
.param lvp_diode_mcd = 'lvp_diode_mcz'
.param lvp_diode = {0.0+MC_PR_SWITCH*1.0*lvp_diode_mcd}
.param lvp_mobility_mcz = 'agauss(0,1,1)'
.param lvp_mobility_mcd = 'lvp_mobility_mcz'
.param lvp_mobility = {0.0+MC_PR_SWITCH*2.0*lvp_mobility_mcd}
.param lvp_saturation_mcz = 'agauss(0,1,1)'
.param lvp_saturation_mcd = 'lvp_saturation_mcz'
.param lvp_saturation = {0.0+MC_PR_SWITCH*1.1*lvp_saturation_mcd}
.param lvp_subvt_mcz = 'agauss(0,1,1)'
.param lvp_subvt_mcd = 'lvp_subvt_mcz'
.param lvp_subvt = {0.0+MC_PR_SWITCH*1.0*lvp_subvt_mcd}
.param lvp_threshold_mcz = 'agauss(0,1,1)'
.param lvp_threshold_mcd = 'lvp_threshold_mcz'
.param lvp_threshold = {0.0+MC_PR_SWITCH*1.0*lvp_threshold_mcd}
.param lvtox_mcz = 'agauss(0,1,1)'
.param lvtox_mcd = 'lvtox_mcz'
.param lvtox = {0.0+MC_PR_SWITCH*1.1*lvtox_mcd}
.param mim_mcz = 'agauss(0,1,1)'
.param mim_mcd = 'mim_mcz'
.param mim = {0.0+MC_PR_SWITCH*1.0*mim_mcd}
.param hvntvn_threshold_mcz = 'agauss(0,1,1)'
.param hvntvn_threshold_mcd = 'hvntvn_threshold_mcz'
.param hvntvn_threshold = {0.0+MC_PR_SWITCH*1.0*hvntvn_threshold_mcd}
.param nfet_20v0_nvt_mcz = 'agauss(0,1,1)'
.param nfet_20v0_nvt_mcd = 'nfet_20v0_nvt_mcz'
.param nfet_20v0_nvt = {0.0+MC_PR_SWITCH*1.0*nfet_20v0_nvt_mcd}
.param nfet_20v0_nvt_iso_mcz = 'agauss(0,1,1)'
.param nfet_20v0_nvt_iso_mcd = 'nfet_20v0_nvt_iso_mcz'
.param nfet_20v0_nvt_iso = {0.0+MC_PR_SWITCH*1.0*nfet_20v0_nvt_iso_mcd}
.param nfet_20v0_mcz = 'agauss(0,1,1)'
.param nfet_20v0_mcd = 'nfet_20v0_mcz'
.param nfet_20v0 = {0.0+MC_PR_SWITCH*1.0*nfet_20v0_mcd}
.param nfet_20v0_iso_mcz = 'agauss(0,1,1)'
.param nfet_20v0_iso_mcd = 'nfet_20v0_iso_mcz'
.param nfet_20v0_iso = {0.0+MC_PR_SWITCH*1.0*nfet_20v0_iso_mcd}
.param n20zvtvh1defet_mcz = 'agauss(0,1,1)'
.param n20zvtvh1defet_mcd = 'n20zvtvh1defet_mcz'
.param n20zvtvh1defet = {0.0+MC_PR_SWITCH*1.0*n20zvtvh1defet_mcd}
.param nfet_20v0_zvt_mcz = 'agauss(0,1,1)'
.param nfet_20v0_zvt_mcd = 'nfet_20v0_zvt_mcz'
.param nfet_20v0_zvt = {0.0+MC_PR_SWITCH*1.0*nfet_20v0_zvt_mcd}
.param ndiff_cd_mcz = 'agauss(0,1,1)'
.param ndiff_cd_mcd = 'ndiff_cd_mcz'
.param ndiff_cd = {0.0+MC_PR_SWITCH*1.5*ndiff_cd_mcd}
.param pfet_20v0_mcz = 'agauss(0,1,1)'
.param pfet_20v0_mcd = 'pfet_20v0_mcz'
.param pfet_20v0 = {0.0+MC_PR_SWITCH*1.0*pfet_20v0_mcd}
.param pdiff_cd_mcz = 'agauss(0,1,1)'
.param pdiff_cd_mcd = 'pdiff_cd_mcz'
.param pdiff_cd = {0.0+MC_PR_SWITCH*1.5*pdiff_cd_mcd}
.param nfet_01v8_lvt_mcz = 'agauss(0,1,1)'
.param nfet_01v8_lvt_mcd = 'nfet_01v8_lvt_mcz'
.param nfet_01v8_lvt = {0.0+MC_PR_SWITCH*1.0*nfet_01v8_lvt_mcd}
.param special_nfet_pass_lvt_mcz = 'agauss(0,1,1)'
.param special_nfet_pass_lvt_mcd = 'special_nfet_pass_lvt_mcz'
.param special_nfet_pass_lvt = {0.0+MC_PR_SWITCH*1.0*special_nfet_pass_lvt_mcd}
.param sky130_fd_pr__npn_05v5_all_mcz = 'agauss(0,1,1)'
.param sky130_fd_pr__npn_05v5_all_mcd = 'sky130_fd_pr__npn_05v5_all_mcz'
.param sky130_fd_pr__npn_05v5_all = {0.0+MC_PR_SWITCH*1.0*sky130_fd_pr__npn_05v5_all_mcd}
.param nfet_g5v0d16v0_mcz = 'agauss(0,1,1)'
.param nfet_g5v0d16v0_mcd = 'nfet_g5v0d16v0_mcz'
.param nfet_g5v0d16v0 = {0.0+MC_PR_SWITCH*1.0*nfet_g5v0d16v0_mcd}
.param pfet_01v8_mvt_mcz = 'agauss(0,1,1)'
.param pfet_01v8_mvt_mcd = 'pfet_01v8_mvt_mcz'
.param pfet_01v8_mvt = {0.0+MC_PR_SWITCH*1.0*pfet_01v8_mvt_mcd}
.param pnp_05v5_W0p68L0p68_mcz = 'agauss(0,1,1)'
.param pnp_05v5_W0p68L0p68_mcd = 'pnp_05v5_W0p68L0p68_mcz'
.param pnp_05v5_W0p68L0p68 = {0.0+MC_PR_SWITCH*1.0*pnp_05v5_W0p68L0p68_mcd}
.param poly_cd_mcz = 'agauss(0,1,1)'
.param poly_cd_mcd = 'poly_cd_mcz'
.param poly_cd = {0.0+MC_PR_SWITCH*1.5*poly_cd_mcd}
.param pfet_01v8_mcz = 'agauss(0,1,1)'
.param pfet_01v8_mcd = 'pfet_01v8_mcz'
.param pfet_01v8 = {0.0+MC_PR_SWITCH*1.0*pfet_01v8_mcd}
.param pfet_g5v0d16v0_mcz = 'agauss(0,1,1)'
.param pfet_g5v0d16v0_mcd = 'pfet_g5v0d16v0_mcz'
.param pfet_g5v0d16v0 = {0.0+MC_PR_SWITCH*1.0*pfet_g5v0d16v0_mcd}
.param well_diode_mcz = 'agauss(0,1,1)'
.param well_diode_mcd = 'well_diode_mcz'
.param well_diode = {0.0+MC_PR_SWITCH*1.0*well_diode_mcd}
* statistics {
*  process {
*     vary cnwvc dist=gauss std=1.0
*     vary diff_cd dist=gauss std=1.5
*     vary hvn_bodyeffect dist=gauss std=2.8
*     vary hvn_diode dist=gauss std=1.0
*     vary hvn_mobility dist=gauss std=0.8
*     vary hvn_saturation dist=gauss std=0.6
*     vary hvn_subvt dist=gauss std=1.0
*     vary hvn_threshold dist=gauss std=1.5
*     vary hvp_bodyeffect dist=gauss std=2.8
*     vary hvp_diode dist=gauss std=1.0
*     vary hvp_mobility dist=gauss std=1.8
*     vary hvp_saturation dist=gauss std=1.8
*     vary hvp_subvt dist=gauss std=1.0
*     vary hvp_threshold dist=gauss std=1.5
*     vary hvtox dist=gauss std=1.0
*     vary ic_cap dist=gauss std=1.0
*     vary ic_res dist=gauss std=1.0
*     vary ic_res_ndiff dist=gauss std=1.0
*     vary ic_res_pdiff dist=gauss std=1.0
*     vary ic_res_poly dist=gauss std=1.0
*     vary ic_res_pwell dist=gauss std=1.0
*     vary lvhp_bodyeffect dist=gauss std=1.8
*     vary lvhp_mobility dist=gauss std=2.0
*     vary lvhp_saturation dist=gauss std=1.1
*     vary lvhp_threshold dist=gauss std=0.8
*     vary lvln_bodyeffect dist=gauss std=2.0
*     vary lvln_mobility dist=gauss std=0.6
*     vary lvln_saturation dist=gauss std=0.6
*     vary lvln_threshold dist=gauss std=0.6
*     vary lvlp_bodyeffect dist=gauss std=0.5
*     vary lvlp_mobility dist=gauss std=0.3
*     vary lvlp_saturation dist=gauss std=0.3
*     vary lvlp_threshold dist=gauss std=1.3
*     vary lvn_bodyeffect dist=gauss std=2.0
*     vary lvn_diode dist=gauss std=1.0
*     vary lvn_mobility dist=gauss std=0.6
*     vary lvn_saturation dist=gauss std=0.6
*     vary lvn_subvt dist=gauss std=1.0
*     vary lvn_threshold dist=gauss std=0.8
*     vary lvp_bodyeffect dist=gauss std=1.0
*     vary lvp_diode dist=gauss std=1.0
*     vary lvp_mobility dist=gauss std=2.0
*     vary lvp_saturation dist=gauss std=1.1
*     vary lvp_subvt dist=gauss std=1.0
*     vary lvp_threshold dist=gauss std=1.0
*     vary lvtox dist=gauss std=1.1
*     vary mim dist=gauss std=1.0
*     vary hvntvn_threshold dist=gauss std=1.0
*     vary nfet_20v0_nvt dist=gauss std=1.0
*     vary nfet_20v0_nvt_iso dist=gauss std=1.0
*     vary nfet_20v0 dist=gauss std=1.0
*     vary nfet_20v0_iso dist=gauss std=1.0
*     vary n20zvtvh1defet dist=gauss std=1.0
*     vary nfet_20v0_zvt dist=gauss std=1.0
*     vary ndiff_cd dist=gauss std=1.5
*     vary pfet_20v0 dist=gauss std=1.0
*     vary pdiff_cd dist=gauss std=1.5
*     vary nfet_01v8_lvt dist=gauss std=1.0
*     vary special_nfet_pass_lvt dist=gauss std=1.0
*     vary sky130_fd_pr__npn_05v5_all dist=gauss std=1.0
*     vary nfet_g5v0d16v0 dist=gauss std=1.0
*     vary pfet_01v8_mvt dist=gauss std=1.0
*     vary pnp_05v5_W0p68L0p68 dist=gauss std=1.0
*     vary poly_cd dist=gauss std=1.5
*     vary pfet_01v8 dist=gauss std=1.0
*     vary pfet_g5v0d16v0 dist=gauss std=1.0
*     vary well_diode dist=gauss std=1.0
*   }
*   mismatch {
*   }
* }
