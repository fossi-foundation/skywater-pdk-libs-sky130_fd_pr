model m_short sp_resistor r=0.01
subckt short (1 2 SUB)
parameters l=0 w=0
R0 (1 2) resistor r=short
ends
subckt sky130_fd_pr__res_generic_nd__hv (t1 t2 b)
parameters w=1 l=1
r0 (t1 t2) resistor r=rndiff_v5
d0 (b t1) m_sky130_fd_pr__diode_pw2nd_11v0 area=w * l * 0.5 pj=w + l
d1 (b t2) m_sky130_fd_pr__diode_pw2nd_11v0 area=w * l * 0.5 pj=w + l
ends // sky130_fd_pr__res_generic_nd__hv
subckt sky130_fd_pr__res_generic_pd__hv (t1 t2 b)
parameters w=1 l=1
r0 (t1 t2) resistor r=rpdiff_v5
d0 (t1 b) m_sky130_fd_pr__diode_pd2nw_11v0 area=w * l * 0.5 pj=w + l
d1 (t1 b) m_sky130_fd_pr__diode_pd2nw_11v0 area=w * l * 0.5 pj=w + l
ends // sky130_fd_pr__res_generic_pd__hv
subckt sky130_fd_pr__res_high_po_0p35 (r0 r1 sub)
parameters mult=1 l=1
x0 (r0 r1 sub) sky130_fd_pr__res_high_po l=l w=0.35 mult=mult
ends // sky130_fd_pr__res_high_po_0p35
subckt sky130_fd_pr__res_high_po_0p69 (r0 r1 sub)
parameters mult=1 l=1
x0 (r0 r1 sub) sky130_fd_pr__res_high_po l=l w=0.69 mult=mult
ends // sky130_fd_pr__res_high_po_0p69
subckt sky130_fd_pr__res_high_po_1p41 (r0 r1 sub)
parameters mult=1 l=1
x0 (r0 r1 sub) sky130_fd_pr__res_high_po l=l w=1.41 mult=mult
ends // sky130_fd_pr__res_high_po_1p41
subckt sky130_fd_pr__res_high_po_2p85 (r0 r1 sub)
parameters mult=1 l=1
x0 (r0 r1 sub) sky130_fd_pr__res_high_po l=l w=2.85 mult=mult
ends // sky130_fd_pr__res_high_po_2p85
subckt sky130_fd_pr__res_high_po_5p73 (r0 r1 sub)
parameters mult=1 l=1
x0 (r0 r1 sub) sky130_fd_pr__res_high_po l=l w=5.73 mult=mult
ends // sky130_fd_pr__res_high_po_5p73
subckt sky130_fd_pr__res_xhigh_po_0p35 (r0 r1 sub)
parameters mult=1 l=1
x0 (r0 r1 sub) sky130_fd_pr__res_xhigh_po l=l w=0.35 mult=mult
ends // sky130_fd_pr__res_xhigh_po_0p35
subckt sky130_fd_pr__res_xhigh_po_0p69 (r0 r1 sub)
parameters mult=1 l=1
x0 (r0 r1 sub) sky130_fd_pr__res_xhigh_po l=l w=0.69 mult=mult
ends // sky130_fd_pr__res_xhigh_po_0p69
subckt sky130_fd_pr__res_xhigh_po_1p41 (r0 r1 sub)
parameters mult=1 l=1
x0 (r0 r1 sub) sky130_fd_pr__res_xhigh_po l=l w=1.41 mult=mult
ends // sky130_fd_pr__res_xhigh_po_1p41
subckt sky130_fd_pr__res_xhigh_po_2p85 (r0 r1 sub)
parameters mult=1 l=1
x0 (r0 r1 sub) sky130_fd_pr__res_xhigh_po l=l w=2.85 mult=mult
ends // sky130_fd_pr__res_xhigh_po_2p85
subckt sky130_fd_pr__res_xhigh_po_5p73 (r0 r1 sub)
parameters mult=1 l=1
x0 (r0 r1 sub) sky130_fd_pr__res_xhigh_po l=l w=5.73 mult=mult
ends // sky130_fd_pr__res_xhigh_po_5p73
