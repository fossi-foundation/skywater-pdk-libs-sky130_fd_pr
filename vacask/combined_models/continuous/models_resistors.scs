parameters tc1rsn=1.422E-03
parameters tc2rsn=6.569e-7
parameters tc1rsp=1.259e-3
parameters tc2rsp=2.204e-6
parameters tc1rsn_h=1.405E-03
parameters tc2rsn_h=4.233e-7
parameters tc1rsp_h=1.369e-3
parameters tc2rsp_h=1.476e-6
parameters tc1rsnw=1.483e-3
parameters tc2rsnw=7.824e-6
parameters tc1rsgpw=8.100e-04
parameters tc2rsgpw=7.840e-7
parameters tc1rsgpu=8.916e-4
parameters tc2rsgpu=8.443e-7
parameters tc1rl1=6.045e-4
parameters tc2rl1=-3.693e-7
parameters tc1sky130_fd_pr__res_generic_m1=3.179e-3
parameters tc2sky130_fd_pr__res_generic_m1=3.094e-7
parameters tc1sky130_fd_pr__res_generic_m2=3.161e-3
parameters tc2sky130_fd_pr__res_generic_m2=-7.272e-7
parameters tc1sky130_fd_pr__res_generic_m3=3.424e-3
parameters tc2sky130_fd_pr__res_generic_m3=-7.739e-7
parameters tc1sky130_fd_pr__res_generic_m4=3.424e-3
parameters tc2sky130_fd_pr__res_generic_m4=-7.739e-7
parameters tc1sky130_fd_pr__res_generic_m5=3.500e-3
parameters tc2sky130_fd_pr__res_generic_m5=-7.500e-7
parameters tc1rrdl=3.930e-3
parameters tc2rrdl=0.0
parameters tc1rcn=2.254e-4
parameters tc2rcn=-1.038e-6
parameters tc1rcp=5.250e-4
parameters tc2rcp=3.544e-6
parameters tc1rcgp=1.249e-3
parameters tc2rcgp=-6.647e-6
parameters tc1rcl1=1.067e-3
parameters tc2rcl1=-5.324e-6
parameters tc1rvia=1.081e-3
parameters tc2rvia=-1.903e-7
parameters tc1rvia2=2.366e-3
parameters tc2rvia2=-1.025e-5
parameters tc1rvia3=2.366e-3
parameters tc2rvia3=-1.025e-5
parameters tc1rvia4=1.77e-03
parameters tc2rvia4=-1.60e-07
parameters tc1rrdlcon=3.930e-3
parameters tc2rrdlcon=0.0
parameters tc1sky130_fd_pr__res_generic_pobody=0.514e-3
parameters tc2sky130_fd_pr__res_generic_pobody=0.122e-5
parameters tc1sky130_fd_pr__res_generic_poend=0.0
parameters tc2sky130_fd_pr__res_generic_poend=0.0
parameters nfom_dw=0.017u pfom_dw=0.004u poly_dw=-0.056u li_dw=0.017u m1_dw=-0.039u m2_dw=-0.039u m3_dw=-0.025u m4_dw=-0.025u m5_dw=-0.09u rdl_dw=0.0u
model m_rndiff sp_resistor tc1=tc1rsn tc2=tc2rsn rsh=sw_rdn dw=-sw_activecd - nfom_dw / 2 tnom=30
model m_rpdiff sp_resistor tc1=tc1rsp tc2=tc2rsp rsh=sw_rdp dw=-sw_activecd - pfom_dw / 2 tnom=30
model m_rndiff_v5 sp_resistor tc1=tc1rsn_h tc2=tc2rsn_h rsh=sw_rdn * 0.95 dw=-sw_activecd - nfom_dw / 2 tnom=30
model m_rpdiff_v5 sp_resistor tc1=tc1rsp_h tc2=tc2rsp_h rsh=sw_rdp * 0.97 dw=-sw_activecd - pfom_dw / 2 tnom=30
model m_rnwell sp_resistor tc1=tc1rsnw tc2=tc2rsnw rsh=sw_rnw dw=-sw_activecd / 2 tnom=30
model m_sky130_fd_pr__res_generic_l1 sp_resistor tc1=tc1rl1 tc2=tc2rl1 rsh=sw_rl1 dw=-sw_rl1_dw / 2 - li_dw / 2 tnom=30
model m_sky130_fd_pr__res_generic_m1 sp_resistor tc1=tc1sky130_fd_pr__res_generic_m1 tc2=tc2sky130_fd_pr__res_generic_m1 rsh=sw_sky130_fd_pr__res_generic_m1_rs dw=-sw_m1_dw / 2 - m1_dw / 2 tnom=30
model m_sky130_fd_pr__res_generic_m2 sp_resistor tc1=tc1sky130_fd_pr__res_generic_m2 tc2=tc2sky130_fd_pr__res_generic_m2 rsh=sw_sky130_fd_pr__res_generic_m2_rs dw=-sw_m2_dw / 2 - m2_dw / 2 tnom=30
model m_sky130_fd_pr__res_generic_m3 sp_resistor tc1=tc1sky130_fd_pr__res_generic_m3 tc2=tc2sky130_fd_pr__res_generic_m3 rsh=sw_sky130_fd_pr__res_generic_m3_rs dw=-sw_m3_dw / 2 - m3_dw / 2 tnom=30
model m_sky130_fd_pr__res_generic_m4 sp_resistor tc1=tc1sky130_fd_pr__res_generic_m4 tc2=tc2sky130_fd_pr__res_generic_m4 rsh=sw_sky130_fd_pr__res_generic_m4_rs dw=-sw_m4_dw / 2 - m4_dw / 2 tnom=30
model m_sky130_fd_pr__res_generic_m5 sp_resistor tc1=tc1sky130_fd_pr__res_generic_m5 tc2=tc2sky130_fd_pr__res_generic_m5 rsh=sw_sky130_fd_pr__res_generic_m5_rs dw=-sw_m5_dw / 2 - m5_dw / 2 tnom=30
model m_mrrdl sp_resistor tc1=tc1rrdl tc2=tc2rrdl rsh=rrdl dw=-tol_rdl / 2 - rdl_dw / 2 tnom=25
model m_mrcn sp_resistor tc1=tc1rcn tc2=tc2rcn res=rcn tnom=30
model m_mrcp sp_resistor tc1=tc1rcp tc2=tc2rcp res=rcp tnom=30
model m_mrcp1 sp_resistor tc1=tc1rcgp tc2=tc2rcgp res=rcp1 tnom=30
model m_mrcl1 sp_resistor tc1=tc1rcl1 tc2=tc2rcl1 res=rcl1 tnom=30
model m_mrcvia sp_resistor tc1=tc1rvia tc2=tc2rvia res=rcvia tnom=30
model m_mrcvia2 sp_resistor tc1=tc1rvia2 tc2=tc2rvia2 res=rcvia2 tnom=30
model m_mrcvia3 sp_resistor tc1=tc1rvia3 tc2=tc2rvia3 res=rcvia3 tnom=30
model m_mrcvia4 sp_resistor tc1=tc1rvia4 tc2=tc2rvia4 res=rcvia4 tnom=30
model m_mrcrdlcon sp_resistor tc1=tc1rrdlcon tc2=tc2rrdlcon res=rcrdlcon tnom=25
subckt sky130_fd_pr__res_generic_nd (t1 t2 b)
parameters mult=1 w=1 l=1
r0 (t1 t2) resistor r=rndiff
xd0 (b t1) sky130_fd_pr__diode_pw2nd_05v5 area=w * l * 0.5 perim=w + l
xd1 (b t2) sky130_fd_pr__diode_pw2nd_05v5 area=w * l * 0.5 perim=w + l
ends // sky130_fd_pr__res_generic_nd
subckt sky130_fd_pr__res_generic_pd (t1 t2 b)
parameters mult=1 w=1 l=1
r0 (t1 t2) resistor r=rpdiff
xd0 (t1 b) sky130_fd_pr__model__parasitic__diode_pd2nw area=w * l * 0.5 perim=w + l
xd1 (t2 b) sky130_fd_pr__model__parasitic__diode_pd2nw area=w * l * 0.5 perim=w + l
ends // sky130_fd_pr__res_generic_pd
subckt sky130_fd_pr__res_xhigh_po (r0 r1 sub)
parameters mult=1 w=1 l=1
parameters leff=l - 0.0592 weff=w - 0.056 + 2 * sw_polycd bp2=-0.1228 bq2=1.304 bp22=-0.2874 bp23=0.5252 sub1=1.2 sub2=41.26e-3 sub3=8.697e-3 sub4=24 sub5=39.86 rhead0=188.2 / (weff - 0.0672 * max(0.69 - w, 0) + 1.41) rbody0=sw_sky130_fd_pr__res_xhigh_po_rs * leff / (weff - 0.0672 * max(0.69 - w, 0)) efac=1 / leff * (1 + bp22 / w + bp23 * min(0.2, leff - 0.5) * log(leff / w)) rhead=rhead0 * sw_poly_head_res * (1 + sw_mm_sky130_fd_pr__res_generic_po_head * mismatch_factor * mc_mm_switch * 0 / sqrt(w * mult)) rbody=rbody0 * (1 + sw_mm_sky130_fd_pr__res_xhigh_po * mismatch_factor * mc_mm_switch * 0 / sqrt(w * l * mult))
rend1 (r0 t1) m_reshead r=rhead
rend2 (t2 r1) m_reshead r=rhead
xc0 (r0 sub) sky130_fd_pr__model__parasitic__cap_p2ps w=weff l=l + 2.08 m=0.5
xc1 (r1 sub) sky130_fd_pr__model__parasitic__cap_p2ps w=weff l=l + 2.08 m=0.5
rbody (t1 t2) m_resbody r=rbody * (1 - bp2 + bp2 * sqrt(1 + (bq2 * abs(v(t1, t2)) * efac) ** 2)) * (sub1 + sub2 * tanh(sub3 * (min(v(sub, r1) + v(sub, r1), sub4) + sub5))) / (sub1 + sub2 * tanh(sub3 * sub5))
model m_resbody sp_resistor tc1=-1.47e-3 - 5e-7 * sw_sky130_fd_pr__res_xhigh_po_rs tc2=2.7e-6 tnom=25
model m_reshead sp_resistor tc1=-4.3e-4 tc2=-1.3e-5 tnom=25
ends // sky130_fd_pr__res_xhigh_po
subckt sky130_fd_pr__res_high_po (r0 r1 b)
parameters mult=1 w=1 l=1
parameters rbody_dw=-0.001 + sw_polycd * 2e6 rhead_ps=345.8312 num_con_row=max(floor(0.5 + (w - 0.33) / 0.36), 1) weff=w + rbody_dw - 0.0672 * max(0.69 - w, 0) + 2 * sw_polycd leff=l + 0.247
rhead (r0 rb) resistor r=rhead_model
rbody (rb r1) resistor r=rbody_model
xc0 (r0 b) sky130_fd_pr__model__parasitic__cap_p2ps w=weff l=l + 2.08 m=0.5
xc1 (r1 b) sky130_fd_pr__model__parasitic__cap_p2ps w=weff l=l + 2.08 m=0.5
model m_rhead_model sp_resistor rsh=rhead_ps * sw_poly_head_res * (1 + sw_mm_sky130_fd_pr__res_generic_po_head * mismatch_factor * mc_mm_switch * 0 / sqrt(w * mult))
model m_rbody_model sp_resistor rsh=sw_sky130_fd_pr__res_high_po_rs * (1 + sw_mm_sky130_fd_pr__res_high_po * mismatch_factor * mc_mm_switch * 0 / sqrt(w * l * mult)) tc1=tc1sky130_fd_pr__res_generic_pobody tc2=tc2sky130_fd_pr__res_generic_pobody tnom=30
ends // sky130_fd_pr__res_high_po
subckt sky130_fd_pr__res_generic_po (r0 r1)
parameters mult=1
parameters w=1 l=0 r=0 tc1=tc1rsgpu tc2=tc2rsgpu r_tot=sw_rp1 * l / (w - 1e6 * (sw_polycd * 4 - poly_dw)) + r
Rsky130_fd_pr__res_generic_po (r0 r1) resistor r=r_tot * (1 + sw_mm_sky130_fd_pr__res_generic_po * mismatch_factor * mc_mm_switch * 0 / sqrt(w * l * mult)) tc1=tc1 tc2=tc2
ends // sky130_fd_pr__res_generic_po
subckt sky130_fd_pr__res_iso_pw (r0 r1 b)
parameters mult=1
parameters l=-1 w=2.65 dl=0.52 av=0.0133 bv=0.0302 tnom=30.0 vvt=3.531e-3 ut=7.238e-6 rtot=sw_pw_rs * (1 + sw_mm_sky130_fd_pr__res_iso_pw * mismatch_factor * mc_mm_switch * 0 / sqrt(w * l * mult))
xdnw1 (r0 b) sky130_fd_pr__model__parasitic__diode_pw2dn area=(l + dl) * w * 0.5 perim=(l + dl + w)
xdnw2 (r1 b) sky130_fd_pr__model__parasitic__diode_pw2dn area=(l + dl) * w * 0.5 perim=(l + dl + w)
Rsky130_fd_pr__res_iso_pw (r0 r1) resistor r=rtot * sw_pw_rs_mc * ((l + dl) / w) * (1 - av * (max(v(r0), v(r1)) - min(v(r0), v(r1)))) * (1 + bv * (v(b) - min(v(r0), v(r1)))) * (1 + vvt * (temper - tref) + ut * (temper - tref) * (temper - tref))
ends // sky130_fd_pr__res_iso_pw
