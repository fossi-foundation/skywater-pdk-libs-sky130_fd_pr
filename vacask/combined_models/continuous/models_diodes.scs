subckt sky130_fd_pr__model__parasitic__diode_ps2dn__extended_drain (a c)
parameters mult=1 area=1 perim=1
parameters sky130_fd_pr__nfet_20v0_zvt_cjdnwpsubjunction_mult=7.0510e-01 sky130_fd_pr__nfet_20v0_zvt_mjdnwpsubjunction_mult=1.6541 sky130_fd_pr__nfet_20v0_zvt_pbdnwpsubjunction_mult=1.4206 sky130_fd_pr__nfet_20v0_zvt_vb=30.0 / (1 + 0.2 * (sw_func_dnw_sub_cj - 1))
Dsky130_fd_pr__model__parasitic__diode_ps2dn__extended_drain (a c) m_sky130_fd_pr__model__parasitic__diode_ps2dn_diode area=area pj=perim
model m_sky130_fd_pr__model__parasitic__diode_ps2dn_diode sp_diode  tlevc=1 area=1e12 cj=1.176E-04 * 1e-12 * sw_func_dnw_sub_cj mj=0.56056 * sky130_fd_pr__nfet_20v0_zvt_mjdnwpsubjunction_mult pb=0.21294 * sky130_fd_pr__nfet_20v0_zvt_pbdnwpsubjunction_mult cjsw=8.1380e-010 * sky130_fd_pr__nfet_20v0_zvt_cjdnwpsubjunction_mult * 1e-6 * sw_func_dnw_sub_cj mjsw=0.18742 * sky130_fd_pr__nfet_20v0_zvt_mjdnwpsubjunction_mult php=0.21294 * sky130_fd_pr__nfet_20v0_zvt_pbdnwpsubjunction_mult cta=0.0031223 ctp=0.0014703 tpb=0.0016859 tphp=0.0016859 js=6.1049e-017 jsw=8.1115e-016 n=0.9891 rs=900 * 1e-12 ik=2.08e-009 / 1e-12 ikr=0 bv=sky130_fd_pr__nfet_20v0_zvt_vb ibv=0.00106 trs=0 eg=1.17 xti=1.0 tnom=30 tcv=0 gap1=0.000473 gap2=1110 ttt1=0 ttt2=0 tm1=0 tm2=0 lm=0 lp=0 wm=0 wp=0 xm=0 xoi=10000 xom=10000 xp=0 xw=0
ends // sky130_fd_pr__model__parasitic__diode_ps2dn__extended_drain
subckt sky130_fd_pr__model__parasitic__diode_ps2dn (a c)
parameters mult=1 area=1 perim=1
Dsky130_fd_pr__model__parasitic__diode_ps2dn (a c) m_sky130_fd_pr__model__parasitic__diode_ps2dn_diode area=area pj=perim
model m_sky130_fd_pr__model__parasitic__diode_ps2dn_diode sp_diode  tlevc=1 area=1e12 cj=sw_dnw_sub_cj * 1e-12 mj=0.49 pb=0.5348 cjsw=8.1664e-010 * 1e-6 * sw_func_dnw_sub_cj mjsw=0.20024 php=0.5348 cta=0.0016157 ctp=0.0008 tpb=0.0025003 tphp=0.001675 js=6.1049e-017 jsw=8.1115e-016 n=1.0791 rs=900 * 1e-12 ik=2.08e-009 / 1e-12 ikr=0 / 1e-12 bv=16.95 / (1 + 0.2 * (sw_func_dnw_sub_cj - 1)) ibv=0.00106 trs=0 eg=1.17 xti=1.0 tnom=30 tcv=0 gap1=0.000473 gap2=1110 ttt1=0 ttt2=0 tm1=0 tm2=0 lm=0 lp=0 wm=0 wp=0 xm=0 xoi=10000 xom=10000 xp=0 xw=0
ends // sky130_fd_pr__model__parasitic__diode_ps2dn
subckt sky130_fd_pr__model__parasitic__diode_pw2dn_defet (a c)
parameters mult=1 area=1 perim=1
Dsky130_fd_pr__model__parasitic__diode_pw2dn_defet (a c) m_diodeint area=area pj=perim
model m_diodeint sp_diode  tlevc=1 area=1e12 cj=sw_pw_dnw_cj * 1e-12 * 7.5058e-01 mj=0.63982 * 8.3390e-01 pb=0.58758 * 1.0204e+00 cjsw=3.743e-010 * 1e-6 * sw_func_pw_dnw_cj * 7.5058e-01 mjsw=0.80357 * 8.3390e-01 php=0.2500 * 1.0204e+00 cta=0.0016157 ctp=0.0008 tpb=0.0010003 tphp=0.000675 minr=1e-3 js=1.4693e-017 jsw=7.41e-018 n=1.0791 rs=900 * 1e-12 ik=2.08e-009 / 1e-12 ikr=0 / 1e-12 bv=26 / (1 + 0.3 * (sw_func_pw_dnw_cj - 1)) ibv=0.00106 trs=0 xti=3.0 eg=1.50 tnom=30 tcv=0 gap1=0.000473 gap2=1110 ttt1=0 ttt2=0 tm1=0 tm2=0 lm=0 lp=0 wm=0 wp=0 xm=0 xoi=10000 xom=10000 xp=0 xw=0
ends // sky130_fd_pr__model__parasitic__diode_pw2dn_defet
subckt sky130_fd_pr__model__parasitic__diode_pw2dn (a c)
parameters mult=1 area=1 perim=1
Dsky130_fd_pr__model__parasitic__diode_pw2dn (a c) m_diodeint area=area pj=perim
model m_diodeint sp_diode  tlevc=1 area=1e12 cj=sw_pw_dnw_cj * 1e-12 mj=0.33982 pb=0.58758 cjsw=3.743e-010 * 1e-6 * sw_func_pw_dnw_cj mjsw=0.23357 php=0.5348 cta=0.0016157 ctp=0.0008 tpb=0.0025003 tphp=0.001675 js=1.4693e-017 jsw=7.41e-018 n=1.0791 rs=900 * 1e-12 ik=2.08e-009 / 1e-12 ikr=0 / 1e-12 bv=16.38 / (1 + 0.3 * (sw_func_pw_dnw_cj - 1)) ibv=0.00106 trs=0 eg=1.17 xti=3.0 tnom=30 tcv=0 gap1=0.000473 gap2=1110 ttt1=0 ttt2=0 tm1=0 tm2=0 lm=0 lp=0 wm=0 wp=0 xm=0 xoi=10000 xom=10000 xp=0 xw=0
ends // sky130_fd_pr__model__parasitic__diode_pw2dn
subckt sky130_fd_pr__diode_pw2nd_05v5_defet (a c)
parameters mult=1 area=1 perim=1
Dsky130_fd_pr__diode_pw2nd_05v5_defet (a c) m_diodeint area=area pj=perim
model m_diodeint sp_diode minr=0.001  tlevc=1 area=1e12 cj=sw_nsd_pw_cj * 1e-12 mj=0.44 pb=0.729 * 2.7281 cjsw=3.6001e-011 * 1e-6 * sw_func_nsd_pw_cj mjsw=0.0009 php=0.2 cta=0.000792 ctp=1e-005 tpb=0.0012287 tphp=0 js=2.75e-015 jsw=6e-016 n=1.2928 rs=981 * 1e-12 ik=1.3e-009 / 1e-12 ikr=0 / 1e-12 bv=11.7 / sw_func_nsd_pw_cj ibv=0.00106 trs=0 eg=1.05 xti=2 tnom=30 tcv=0 gap1=0.000473 gap2=1110 ttt1=0 ttt2=0 tm1=0 tm2=0 lm=0 lp=0 wm=0 wp=0 xm=0 xoi=10000 xom=10000 xp=0 xw=0
ends // sky130_fd_pr__diode_pw2nd_05v5_defet
subckt sky130_fd_pr__diode_pw2nd_05v5_esd (c0 c1)
parameters mult=1 area=1 perim=1
xd1 (a1 c1) sky130_fd_pr__diode_pw2nd_05v5 area=area * 1.54 perim=perim rs_int=0 * 1e-12
Rsky130_fd_pr__diode_pw2nd_05v5_esd (c0 a1) resistor r=1.1101
ends // sky130_fd_pr__diode_pw2nd_05v5_esd
subckt sky130_fd_pr__diode_pw2nd_05v5_esd_v5 (c0 c1)
parameters mult=1 area=1 perim=1
xd1 (a1 c1) sky130_fd_pr__diode_pw2nd_11v0 area=area * 1.54 perim=perim rs_int=0 * 1e-12
Rsky130_fd_pr__diode_pw2nd_05v5_esd_v5 (c0 a1) resistor r=1.1101
ends // sky130_fd_pr__diode_pw2nd_05v5_esd_v5
subckt sky130_fd_pr__diode_pw2nd_05v5_lvt (a c)
parameters mult=1 area=1 perim=1
Dsky130_fd_pr__diode_pw2nd_05v5_lvt (a c) m_diodeint area=area pj=perim
model m_diodeint sp_diode  tlevc=1 area=1e12 cj=1.210E-03 * 1e-12 * sw_func_nsd_pw_cj mj=0.42197 pb=0.7477 cjsw=3.6224e-011 * 1e-6 * sw_func_nsd_pw_cj mjsw=0.001 php=0.1 cta=0.000792 ctp=1e-005 tpb=0.0012287 tphp=0 js=2.75e-015 jsw=6e-016 n=1.2928 rs=981 * 1e-12 ik=1.3e-009 / 1e-12 ikr=0 / 1e-12 bv=11.9 / sw_func_nsd_pw_cj ibv=0.00106 trs=0 eg=1.05 xti=2 tnom=30 tcv=0 gap1=0.000473 gap2=1110 ttt1=0 ttt2=0 tm1=0 tm2=0 lm=0 lp=0 wm=0 wp=0 xm=0 xoi=10000 xom=10000 xp=0 xw=0
ends // sky130_fd_pr__diode_pw2nd_05v5_lvt
subckt sky130_fd_pr__diode_pw2nd_05v5_nvt (a c)
parameters mult=1 area=1 perim=1
Dsky130_fd_pr__diode_pw2nd_05v5_nvt (a c) m_diodeint area=area pj=perim
model m_diodeint sp_diode  tlevc=1 area=1e12 cj=8.310E-04 * 1e-12 * sw_func_nsd_pw_cj mj=0.28329 pb=0.66345 cjsw=8.5152e-011 * 1e-6 * sw_func_nsd_pw_cj mjsw=0.057926 php=1 cta=0.00083 ctp=0 tpb=0.0019685 tphp=0.001 js=4.2966e-016 jsw=8.04e-016 n=1.5764 rs=600 * 1e-12 ik=4.76e-008 / 1e-12 ikr=0 / 1e-12 bv=12.69 / sw_func_nsd_pw_cj ibv=0.00106 trs=0 eg=1.05 xti=0 tnom=30 tcv=0 gap1=0.000473 gap2=1110 ttt1=0 ttt2=0 tm1=0 tm2=0 lm=0 lp=0 wm=0 wp=0 xm=0 xoi=10000 xom=10000 xp=0 xw=0
ends // sky130_fd_pr__diode_pw2nd_05v5_nvt
subckt sky130_fd_pr__diode_pw2nd_05v5 (a c)
parameters mult=1 area=1 perim=1
parameters rs_int=981 * 1e-12
Dsky130_fd_pr__diode_pw2nd_05v5 (a c) m_ndiode area=area pj=perim
model m_ndiode sp_diode  tlevc=1 area=1e12 cj=sw_nsd_pw_cj * 1e-12 mj=0.44 pb=0.729 cjsw=3.6001e-011 * 1e-6 * sw_func_nsd_pw_cj mjsw=0.0009 php=0.2 cta=0.000792 ctp=1e-005 tpb=0.0012287 tphp=0 js=2.75e-015 jsw=6e-016 n=1.2928 rs=rs_int ik=1.3e-009 / 1e-12 ikr=0 bv=11.7 / sw_func_nsd_pw_cj ibv=0.00106 trs=0 eg=1.05 xti=2 tnom=30 tcv=0 gap1=0.000473 gap2=1110 ttt1=0 ttt2=0 tm1=0 tm2=0 lm=0 lp=0 wm=0 wp=0 xm=0 xoi=10000 xom=10000 xp=0 xw=0
ends // sky130_fd_pr__diode_pw2nd_05v5
subckt sky130_fd_pr__diode_pw2nd_11v0 (a c)
parameters mult=1 area=1 perim=1
parameters rs_int=981 * 1e-12
Dsky130_fd_pr__diode_pw2nd_11v0 (a c) m_ndiode_h area=area pj=perim
model m_ndiode_h sp_diode  tlevc=1 area=1e12 cj=0.0008512 * 1e-12 * sw_func_nsd_pw_cj mj=0.295 pb=0.72468 cjsw=8.5204e-011 * 1e-6 * sw_func_nsd_pw_cj mjsw=0.037586 php=0.29067 cta=0.00067434 ctp=0.0002493 tpb=0.001344 tphp=0.00099005 js=3.75e-016 jsw=5.84e-017 n=1.0773 rs=rs_int ik=1.3e-009 / 1e-12 ikr=0 / 1e-12 bv=12.636 / sw_func_nsd_pw_cj ibv=0.00106 trs=0 eg=0.92 xti=0.76 tnom=30 tcv=0 gap1=0.000473 gap2=1110 ttt1=0 ttt2=0 tm1=0 tm2=0 lm=0 lp=0 wm=0 wp=0 xm=0 xoi=10000 xom=10000 xp=0 xw=0
ends // sky130_fd_pr__diode_pw2nd_11v0
subckt sky130_fd_pr__model__parasitic__diode_pd2nw (a c)
parameters mult=1 area=1 perim=1
Dsky130_fd_pr__model__parasitic__diode_pd2nw (a c) m_diodeint area=area pj=perim
model m_diodeint sp_diode  tlevc=1 area=1e12 cj=sw_nw_pw_cj * 1e-12 mj=0.4509 pb=0.5348 cjsw=5.822e-010 * 1e-6 * sw_func_nw_pw_cj mjsw=0.2433 php=0.5348 cta=0.00165 ctp=0.0008 tpb=0.0022563 tphp=0.00165 js=4.21e-018 jsw=4.94e-018 n=1.0791 rs=900 * 1e-12 ik=2.08e-009 / 1e-12 ikr=0 / 1e-12 bv=16.848 / sw_func_nw_pw_cj ibv=0.00106 trs=0 eg=1.17 xti=5.2 tnom=30 tcv=0 gap1=0.000473 gap2=1110 ttt1=0 ttt2=0 tm1=0 tm2=0 lm=0 lp=0 wm=0 wp=0 xm=0 xoi=10000 xom=10000 xp=0 xw=0
ends // sky130_fd_pr__model__parasitic__diode_pd2nw
subckt sky130_fd_pr__photodiode (a c)
parameters mult=1 area=1 perim=1
Dsky130_fd_pr__photodiode (a c) m_diodeint area=area pj=perim
model m_diodeint sp_diode  tlevc=1 area=1e12 cj=7.8544e-005 * 1e-12 * sw_func_psd_nw_cj mj=0.49 pb=0.5348 cjsw=8.1664e-010 * 1e-6 * sw_func_psd_nw_cj mjsw=0.20024 php=0.5348 cta=0.0016157 ctp=0.0008 tpb=0.0025003 tphp=0.001675 js=6.1049e-017 jsw=8.1115e-016 n=1.0791 rs=900 * 1e-12 ik=2.08e-009 / 1e-12 ikr=0 / 1e-12 bv=16.95 / sw_func_psd_nw_cj ibv=0.00106 trs=0 eg=1.17 xti=1.0 tnom=30 tcv=0 gap1=0.000473 gap2=1110 ttt1=0 ttt2=0 tm1=0 tm2=0 lm=0 lp=0 wm=0 wp=0 xm=0 xoi=10000 xom=10000 xp=0 xw=0
ends // sky130_fd_pr__photodiode
subckt sky130_fd_pr__diode_pd2nw_05v5_esd (c0 c1)
parameters mult=1 area=1 perim=1
xd1 (a1 c1) sky130_fd_pr__diode_pd2nw_05v5 area=area * 1.54 perim=perim rs_int=0 * 1e-12
Rsky130_fd_pr__diode_pd2nw_05v5_esd (c0 a1) resistor r=1.1101
ends // sky130_fd_pr__diode_pd2nw_05v5_esd
subckt sky130_fd_pr__diode_pd2nw_05v5_esd_v5 (c0 c1)
parameters mult=1 area=1 perim=1
xd1 (a1 c1) sky130_fd_pr__diode_pd2nw_11v0 area=area * 1.54 perim=perim rs_int=0 * 1e-12
Rsky130_fd_pr__diode_pd2nw_05v5_esd_v5 (c0 a1) resistor r=1.1101
ends // sky130_fd_pr__diode_pd2nw_05v5_esd_v5
subckt sky130_fd_pr__diode_pd2nw_05v5_hvt (a c)
parameters mult=1 area=1 perim=1
Dsky130_fd_pr__diode_pd2nw_05v5_hvt (a c) m_diodeint area=area pj=perim
model m_diodeint sp_diode  tlevc=1 area=1e12 cj=7.433E-04 * 1e-12 * sw_func_psd_nw_cj mj=0.34629 pb=0.6587 cjsw=9.2435e-011 * 1e-6 * sw_func_psd_nw_cj mjsw=0.26859 php=0.7418 cta=0.0012407 ctp=0 tpb=0.0019551 tphp=0.00014242 js=2.17e-017 jsw=8.2e-016 n=1.2556 rs=600 * 1e-12 ik=4.76e-008 / 1e-12 ikr=0 / 1e-12 bv=12.8 / sw_func_psd_nw_cj ibv=0.00106 trs=0 eg=1.05 xti=2.0 tnom=30 tcv=0 gap1=0.000473 gap2=1110 ttt1=0 ttt2=0 tm1=0 tm2=0 lm=0 lp=0 wm=0 wp=0 xm=0 xoi=10000 xom=10000 xp=0 xw=0
ends // sky130_fd_pr__diode_pd2nw_05v5_hvt
subckt sky130_fd_pr__diode_pd2nw_05v5_lvt (a c)
parameters mult=1 area=1 perim=1
Dsky130_fd_pr__diode_pd2nw_05v5_lvt (a c) m_diodeint area=area pj=perim
model m_diodeint sp_diode  tlevc=1 area=1e12 cj=7.682E-04 * 1e-12 * sw_func_psd_nw_cj mj=0.3362 pb=0.6587 cjsw=9.152e-011 * 1e-6 * sw_func_psd_nw_cj mjsw=0.2659 php=0.7418 cta=0.0012407 ctp=0.00037357 tpb=0.001671 tphp=0.001246 js=2.1483e-017 jsw=1.447e-16 n=1.3632 rs=600 * 1e-12 ik=4.76e-008 / 1e-12 ikr=0 / 1e-12 bv=12.69 / sw_func_psd_nw_cj ibv=0.00106 trs=0 eg=1.05 xti=5.2 tnom=30 tcv=0 gap1=0.000473 gap2=1110 ttt1=0 ttt2=0 tm1=0 tm2=0 lm=0 lp=0 wm=0 wp=0 xm=0 xoi=10000 xom=10000 xp=0 xw=0
ends // sky130_fd_pr__diode_pd2nw_05v5_lvt
subckt sky130_fd_pr__diode_pd2nw_05v5 (a c)
parameters mult=1 area=1 perim=1
parameters rs_int=600 * 1e-12
Dsky130_fd_pr__diode_pd2nw_05v5 (a c) m_pdiode area=area pj=perim
model m_pdiode sp_diode  tlevc=1 area=1e12 cj=sw_psd_nw_cj * 1e-12 mj=0.34629 pb=0.6587 cjsw=9.88e-011 * 1e-6 * sw_func_psd_nw_cj mjsw=0.29781 php=0.7418 cta=0.0012407 ctp=0.00037357 tpb=0.0020386 tphp=0.001246 js=2.1483e-017 jsw=8.04e-016 n=1.3632 rs=rs_int ik=4.76e-008 / 1e-12 ikr=0 bv=12.69 / sw_func_psd_nw_cj ibv=0.00106 trs=0 eg=1.05 xti=5.2 tnom=30 tcv=0 gap1=0.000473 gap2=1110 ttt1=0 ttt2=0 tm1=0 tm2=0 lm=0 lp=0 wm=0 wp=0 xm=0 xoi=10000 xom=10000 xp=0 xw=0
ends // sky130_fd_pr__diode_pd2nw_05v5
subckt sky130_fd_pr__diode_pd2nw_11v0 (a c)
parameters mult=1 area=1 perim=1
parameters rs_int=600 * 1e-12
Dsky130_fd_pr__diode_pd2nw_11v0 (a c) m_pdiode_h area=area pj=perim
model m_pdiode_h sp_diode  tlevc=1 area=1e12 cj=0.00077547 * 1e-12 * sw_func_psd_nw_cj mj=0.33956 pb=0.6587 cjsw=9.8717e-011 * 1e-6 * sw_func_psd_nw_cj mjsw=0.24676 php=1 cta=0.00096 ctp=3e-005 tpb=0.001671 tphp=0 js=2.1483e-017 jsw=4.02e-018 n=1.3632 rs=rs_int ik=4.76e-008 / 1e-12 ikr=0 bv=12.69 / sw_func_psd_nw_cj ibv=0.00106 trs=0 eg=1.05 xti=10 tnom=30 tcv=0 gap1=0.000473 gap2=1110 ttt1=0 ttt2=0 tm1=0 tm2=0 lm=0 lp=0 wm=0 wp=0 xm=0 xoi=10000 xom=10000 xp=0 xw=0
ends // sky130_fd_pr__diode_pd2nw_11v0
