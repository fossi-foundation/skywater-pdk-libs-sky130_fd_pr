// simulatorOptions options scale=1.0u
// simulatorOptions options parser scale=1.0u
parameters lv_dlc_rotweak=.00e-9 hv_dlc_rotweak=.00e-9 sky130_fd_pr__esd_nfet_01v8__dlc_rotweak=lv_dlc_rotweak sky130_fd_pr__special_nfet_pass__dlc_rotweak=lv_dlc_rotweak sky130_fd_pr__special_nfet_pass_lowleakage__dlc_rotweak=lv_dlc_rotweak sky130_fd_pr__special_nfet_pass_flash__dlc_rotweak=hv_dlc_rotweak sky130_fd_pr__special_nfet_latch__dlc_rotweak=lv_dlc_rotweak sky130_fd_pr__special_nfet_latch_lowleakage__dlc_rotweak=lv_dlc_rotweak sky130_fd_pr__special_pfet_latch__dlc_rotweak=lv_dlc_rotweak sky130_fd_pr__special_pfet_latch_lowleakage__dlc_rotweak=lv_dlc_rotweak sky130_fd_bs_flash__special_sonosfet_star__dlc_rotweak=hv_dlc_rotweak sky130_fd_bs_flash__special_sonosfet_original__dlc_rotweak=hv_dlc_rotweak sonos_eeol_dlc_rotweak=hv_dlc_rotweak sonos_peol_dlc_rotweak=hv_dlc_rotweak
include "../sonos_p/begin_of_life/mm.scs"
include "../sonos_e/begin_of_life/mm.scs"
include "../../cells/diode_pd2nw_11v0/sky130_fd_pr__diode_pd2nw_11v0.model.scs"
include "../../cells/diode_pd2nw_11v0/sky130_fd_pr__diode_pd2nw_11v0_no_rs.model.scs"
include "../../cells/esd_rf_diode_pd2nw_11v0/sky130_fd_pr__esd_rf_diode_pd2nw_11v0_100.model.scs"
include "../../cells/esd_rf_diode_pd2nw_11v0/sky130_fd_pr__esd_rf_diode_pd2nw_11v0_200.model.scs"
include "../../cells/esd_rf_diode_pd2nw_11v0/sky130_fd_pr__esd_rf_diode_pd2nw_11v0_300.model.scs"
include "../../cells/diode_pw2nd_11v0/sky130_fd_pr__diode_pw2nd_11v0.model.scs"
include "../../cells/diode_pw2nd_11v0/sky130_fd_pr__diode_pw2nd_11v0_no_rs.model.scs"
include "../../cells/esd_rf_diode_pw2nd_11v0/sky130_fd_pr__esd_rf_diode_pw2nd_11v0_100.model.scs"
include "../../cells/esd_rf_diode_pw2nd_11v0/sky130_fd_pr__esd_rf_diode_pw2nd_11v0_200.model.scs"
include "../../cells/esd_rf_diode_pw2nd_11v0/sky130_fd_pr__esd_rf_diode_pw2nd_11v0_300.model.scs"
include "../../cells/cap_var_hvt/sky130_fd_pr__cap_var_hvt.model.scs"
include "../../cells/cap_var_lvt/sky130_fd_pr__cap_var_lvt.model.scs"
include "../../cells/special_nfet_pass/sky130_fd_pr__special_nfet_pass.pm3.scs"
include "../../cells/special_nfet_latch/sky130_fd_pr__special_nfet_latch.pm3.scs"
include "../../cells/special_pfet_latch/sky130_fd_pr__special_pfet_latch.pm3.scs"
include "../../cells/special_nfet_pass_flash/sky130_fd_pr__special_nfet_pass_flash.pm3.scs"
parameters sky130_fd_pr__rf_nfet_01v8_lvt__base__dlc_rotweak=0
parameters sky130_fd_pr__rf_nfet_01v8__base__dlc_rotweak=0
parameters sky130_fd_pr__rf_pfet_01v8__base__dlc_rotweak=0
parameters sky130_fd_pr__rf_nfet_g5v0d10v5__base__dlc_rotweak=0
include "../../cells/rf_nfet_g5v0d10v5/sky130_fd_pr__rf_nfet_g5v0d10v5.pm3.scs"
include "../../cells/rf_nfet_01v8_lvt/sky130_fd_pr__rf_nfet_01v8_lvt.pm3.scs"
include "../../cells/rf_nfet_01v8/sky130_fd_pr__rf_nfet_01v8.pm3.scs"
include "../../cells/rf_pfet_01v8/sky130_fd_pr__rf_pfet_01v8.pm3.scs"
include "../../cells/rf_pfet_01v8_mvt/sky130_fd_pr__rf_pfet_01v8_mvt.pm3.scs"
