parameters sky130_fd_pr__special_nfet_pass_lvt__toxe_mult=0.948 sky130_fd_pr__special_nfet_pass_lvt__overlap_mult=0.86067 sky130_fd_pr__special_nfet_pass_lvt__ajunction_mult=0.82447 sky130_fd_pr__special_nfet_pass_lvt__pjunction_mult=0.75 sky130_fd_pr__special_nfet_pass_lvt__rshn_mult=0.8 sky130_fd_pr__special_nfet_pass_lvt__lint_diff=1.7325e-8 sky130_fd_pr__special_nfet_pass_lvt__wint_diff=-3.2175e-8 sky130_fd_pr__special_nfet_pass_lvt__dlc_diff=1.1336e-8 sky130_fd_pr__special_nfet_pass_lvt__dwc_diff=-3.2175e-8 sky130_fd_pr__special_nfet_pass_lvt__u0_diff_0=-2.0164e-2 sky130_fd_pr__special_nfet_pass_lvt__vsat_diff_0=-3.8138e+4 sky130_fd_pr__special_nfet_pass_lvt__vth0_diff_0=-9.7123e-2 sky130_fd_pr__special_nfet_pass_lvt__nfactor_diff_0=-3.9755e-1 sky130_fd_pr__special_nfet_pass_lvt__voff_diff_0=0.0 sky130_fd_pr__special_nfet_pass_lvt__k2_diff_0=0.0 sky130_fd_pr__special_nfet_pass_lvt__eta0_diff_0=0.0 sky130_fd_pr__special_nfet_pass_lvt__ua_diff_0=0.0 sky130_fd_pr__special_nfet_pass_lvt__ub_diff_0=0.0
include "sky130_fd_pr__special_nfet_pass_lvt.pm3.scs"
