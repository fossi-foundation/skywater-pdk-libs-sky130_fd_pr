subckt sky130_fd_pr__cap_vpp_11p3x11p3_m1m2m3m4_shieldl1_wafflecap (c0 c1 b)
parameters mult=1.0 ctot_a=110.41e-15 * sky130_fd_pr__model__cap_vpp_finger__cor + 0.0283 / sqrt(mult * 2 * 11.33 * 11.33) * 110.41e-15 * sky130_fd_pr__model__cap_vpp_finger__cor * mc_mm_switch * 0 c0_sub=5.993e-15 * cli2s_vpp c1_sub=2.615e-15 * cli2s_vpp rat_m4=0.125 rat_m3=0.125 rat_m2=0.375 rat_m1=0.375 cap_m4=rat_m4 * ctot_a cap_m3=rat_m3 * ctot_a cap_m2=rat_m2 * ctot_a cap_m1=rat_m1 * ctot_a lm1=11.33 - 0.96 lm2=11.33 - 0.96 lm3=11.33 - 0.96 lm4=11.33 - 0.96 wm1=0.160 wm2=0.160 wm3=0.300 wm4=0.300 nfm1=9.0 nfm2=9.0 nfm3=5.0 nfm4=5.0 nvia3=5.0 nvia2=5.0 nvia=5.0
ccmvpp_hd5_atlas_wafflecap1 (a2 a1) capacitor c=cap_m4
rsm4 (a0 a2) resistor r=rm4 * lm4 / wm4 * (1 / 3) * (1 / nfm4)
rvia3_0 (a0 b0) resistor r=rcvia3 / nvia3
rvia3_1 (a1 b1) resistor r=rcvia3 / nvia3
rsm3 (b0 b2) resistor r=rm3 * lm3 / wm3 * (1 / 3) * (1 / nfm3)
cm3 (b2 b1) capacitor c=cap_m3
rvia2_0 (b0 c0) resistor r=rcvia2 / nvia2
rvia2_1 (b1 c1) resistor r=rcvia2 / nvia2
rsm2 (c0 c2) resistor r=(rm2 * lm2 / wm2 * (1 / 3) * (1 / nfm2) + rm2 * lm2 / wm2)
cm2 (c2 c1) capacitor c=cap_m2
rvia_0 (c0 d0) resistor r=rcvia / nvia
rvia_1 (c1 d1) resistor r=rcvia / nvia
rsm1 (d0 d2) resistor r=rm1 * lm1 / wm1 * (1 / 3) * (1 / nfm1)
cm1 (d2 d1) capacitor c=cap_m1
cm12b_0 (d0 b) capacitor c=c0_sub
cm12b_1 (d1 b) capacitor c=c1_sub
ends // sky130_fd_pr__cap_vpp_11p3x11p3_m1m2m3m4_shieldl1_wafflecap
