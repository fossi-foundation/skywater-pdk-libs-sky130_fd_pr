subckt sky130_fd_pr__cap_var_lvt (c0 c1 b)
parameters w=5 l=0.5 vm=1 wc=w * 1 lc=l * 1
parameters cnwvc_ldiff=0.15 wd=wc + 2 * cnwvc_dwc ld=lc + 2 * cnwvc_dlc ldd=0.018 + 2 * cnwvc_dld dwr=-0.02 dwp=-0.5 dlr=0.02 wl=(wd - 2 * dwr) / (ld - 2 * dlr) wlwdiff=((0.5 * (ld - 2 * dlr)) + cnwvc_ldiff) / (2 * (wd - 2 * dwr)) sky130_fd_pr__cap_var_lvt__cmin_slope_l=1.1e-16 sky130_fd_pr__cap_var_lvt__cmin_slope_w=1.5e-16 sky130_fd_pr__cap_var_lvt__cmin_slope_wl=3.5e-16 sky130_fd_pr__cap_var_lvt__cmax_slope_l=7.0e-16 sky130_fd_pr__cap_var_lvt__cmax_slope_w=7.0e-16 sky130_fd_pr__cap_var_lvt__cmax_slope_wl=1.5e-15
parameters cnwvc_slope1=0.21875
parameters cnwvc_slope2=0.125
parameters cm0=5.571e-16 * cnwvc_cintmult cm1=4.775e-16 + mc_mm_switch * 0 * sky130_fd_pr__cap_var_lvt__cmin_slope_l / sqrt(2 * ld * vm) cm2=2.019e-16 + mc_mm_switch * 0 * sky130_fd_pr__cap_var_lvt__cmin_slope_w / sqrt(2 * wd * vm) cm3=6.529e-16 * cnwvc_cdepmult + mc_mm_switch * 0 * sky130_fd_pr__cap_var_lvt__cmin_slope_wl * cnwvc_cdepmult / sqrt(2 * ld * wd * vm) cx0=6.261e-16 cx1=5.75e-16 + mc_mm_switch * 0 * sky130_fd_pr__cap_var_lvt__cmax_slope_l / sqrt(2 * ld * vm) cx2=1.712e-16 + mc_mm_switch * 0 * sky130_fd_pr__cap_var_lvt__cmax_slope_w / sqrt(2 * wd * vm) cx3=8.854e-14 * 3.9 / cnwvc_tox + mc_mm_switch * 0 * sky130_fd_pr__cap_var_lvt__cmax_slope_wl / sqrt(2 * wd * ld * vm) sky130_fd_pr__cap_var_lvt__vgs_min_1=-2.071 sky130_fd_pr__cap_var_lvt__vgs_max_1=-1 * -2.071 sky130_fd_pr__cap_var_lvt__tmax_vgs_1=100.001n sky130_fd_pr__cap_var_lvt__vgs_min_2=-2.161 sky130_fd_pr__cap_var_lvt__vgs_max_2=-1 * -2.161 sky130_fd_pr__cap_var_lvt__tmax_vgs_2=20.001n sky130_fd_pr__cap_var_lvt__vgs_min=-2.301 sky130_fd_pr__cap_var_lvt__vgs_max=-1 * -2.301
parameters tnom=30.0 cmin=cm0 + cm1 * ld + cm2 * wd + cm3 * wd * (ld - ldd) + cx3 * wd * ldd cmax=cx0 + cx1 * ld + cx2 * wd + cx3 * wd * ld
cg (c0 p2) capacitor q=cmin * vm * (v(c0) - v(p2)) + ((0.5 * (cmax + cmin) - cmin) * (v(c0) - v(p2)) + 0.5 * (cmax - cmin) * (1 / 1.9) * (cnwvc_slope1 * log(cosh((v(c0) - v(p2) - cnwvc_vt1) / cnwvc_slope1)) + 0.9 * cnwvc_slope2 * log(cosh((v(c0) - v(p2) - cnwvc_vt2) / cnwvc_slope2)))) * vm
c3 (c0 b) capacitor c=0.15e-15
c4 (c1 b) capacitor c=0.15e-15
parameters con_sp=0.17
parameters cnwvc_k=12
parameters cnwvc_n1=0.1
parameters cnwvc_n2=0.28
parameters apoly=1.15
parameters apolyc=1
parameters acon=1
parameters anwell=1
parameters bnwell=0.6
parameters cnwell=2
parameters n_pocon=max((lc - 0.14) / (2 * con_sp), 1)
parameters n_con=(wc - 2 * 0.06 + con_sp) / (2 * con_sp)
parameters rg_tc1=3e-3
parameters rg_tc2=0.0
parameters rg_tcmult=1 + (temper - tref) * rg_tc1 + (temper - tref) * (temper - tref) * rg_tc2
parameters cnwvc_a=apoly * rp1 * wl / cnwvc_k + apolyc * rcp1 / n_pocon + acon * rcn / n_con + anwell * rnw * wlwdiff
parameters cnwvc_b1=bnwell * rnw * wlwdiff
parameters cnwvc_c=cnwell * rnw * ((0.5 * (ld - 2 * dlr)) + cnwvc_ldiff) / (2 * (wd - 2 * dwp))
rg (p2 c1) resistor r=(cnwvc_a + cnwvc_b1 * (0.5 * tanh((v(c0) - v(p2) - cnwvc_vtr) / cnwvc_n1) + 0.5) + 20 * cnwvc_c * (0.5 * tanh((v(c0) - v(p2) - cnwvc_vtr) / cnwvc_n1) + 0.5) * exp(-abs((v(c0) - v(p2) - cnwvc_vtr) / cnwvc_n2))) / vm * rg_tcmult
ends // sky130_fd_pr__cap_var_lvt
